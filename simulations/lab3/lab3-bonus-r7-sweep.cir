* Lab 3 第二部分 Bonus：掃 R7（與 C3 串聯的交流旁路電阻）找 |A_v| > 10 的範圍
* 直流偏壓完全不受 R7 影響（C3 擋住直流），只有交流源極阻抗 R6//R7 在變
VDD vdd 0 15
VGS src 0 AC 1
R5 src a 100
C1 a g 1u
R1 vdd g 100k
R2 g 0 50k
R3 vdd d 300k
M1 d g s s BS170
R6 s 0 100k
R7 s2 0 {R7}
C3 s s2 1u
C2 d out 1u
R4 out 0 1Meg
.model BS170 NMOS (Level=3 W=200u L=1u Tox=0.05u Vto=2.14 Kp=4e-4 Vmax=0 Uo=700
+ Phi=0.6 NSUB=1e15 NFS=9e11 Gamma=0.1 Delta=0 Eta=0 Theta=0 Kappa=0.005
+ Rg=0 Rs=0 Rd=0.0 Rb=0 Rds=50e9 Cgso=140n Cgdo=10n Cgbo=10n Cbd=100p
+ Cj=2e-4 Cjsw=1n Is=10f N=1 Pb=.8)
.param R7=30k
.step param R7 list 0.001 100 10k 25k 30k 50k 100k
.ac dec 10 100 10k
.meas ac Av1k FIND V(out) AT 1k
.backanno
.end

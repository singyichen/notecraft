* Lab 3 第二部分 Bonus 定案：只把 R7 由 30k 換成 10k（偏壓完全不動，只降交流源極阻抗）
* R1 100k、R2 50k、R3 300k、R6 100k、R4 1M、R5 100ohm、C1=C2=C3 1uF 全部照原電路
* 掃 V_th 看設計對元件離散的耐受度
VDD vdd 0 15
VGS src 0 SINE(0 0.05 1k) AC 1
R5 src a 100
C1 a g 1u
R1 vdd g 100k
R2 g 0 50k
R3 vdd d 300k
M1 d g s s BS170
R6 s 0 100k
R7 s2 0 10k
C3 s s2 1u
C2 d out 1u
R4 out 0 1Meg
.model BS170 NMOS (Level=3 W=200u L=1u Tox=0.05u Vto={VTO} Kp=4e-4 Vmax=0 Uo=700
+ Phi=0.6 NSUB=1e15 NFS=9e11 Gamma=0.1 Delta=0 Eta=0 Theta=0 Kappa=0.005
+ Rg=0 Rs=0 Rd=0.0 Rb=0 Rds=50e9 Cgso=140n Cgdo=10n Cgbo=10n Cbd=100p
+ Cj=2e-4 Cjsw=1n Is=10f N=1 Pb=.8)
.param VTO=2.14
.step param VTO list 1.2 1.6 2.14 2.6 3.0
.ac dec 10 100 10k
.meas ac Av1k FIND V(out) AT 1k
.backanno
.end

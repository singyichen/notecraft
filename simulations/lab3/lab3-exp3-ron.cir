* Lab 3 實驗三：導通電阻 R_on（講義第 10 頁，I_D 由 10 mA 定電流源灌入，掃 V_GS）
* R1 100 Ω 串在定電流源與汲極之間，對 I_D 沒有影響（定電流源），只影響節點電位
VGS g 0 5
I2 0 dd 10m
R1 dd d 100
M1 d g 0 0 BS170
* --- 2N7000 的替身：LTspice 內建 standard.mos 的 BS170（同族 60 V／500 mA／TO-92 小訊號 NMOS）---
.model BS170 NMOS (Level=3 W=200u L=1u Tox=0.05u Vto=2.14 Kp=4e-4 Vmax=0 Uo=700
+ Phi=0.6 NSUB=1e15 NFS=9e11 Gamma=0.1 Delta=0 Eta=0 Theta=0 Kappa=0.005
+ Rg=0 Rs=0 Rd=0.0 Rb=0 Rds=50e9 Cgso=140n Cgdo=10n Cgbo=10n Cbd=100p
+ Cj=2e-4 Cjsw=1n Is=10f N=1 Pb=.8)
.dc VGS 2 10 0.01
.backanno
.end

* Lab 3 講義問題 5：R1 由 100 kΩ 換成 1 MΩ（閘極分壓塌掉）
VDD vdd 0 15
VGS src 0 AC 1
R5 src a 100
C1 a g 1u
R1 vdd g {RG}
R2 g 0 50k
R3 vdd d 300k
M1 d g s s BS170
R6 s 0 100k
R7 s2 0 30k
C3 s s2 1u
C2 d out 1u
R4 out 0 1Meg
.model BS170 NMOS (Level=3 W=200u L=1u Tox=0.05u Vto=2.14 Kp=4e-4 Vmax=0 Uo=700
+ Phi=0.6 NSUB=1e15 NFS=9e11 Gamma=0.1 Delta=0 Eta=0 Theta=0 Kappa=0.005
+ Rg=0 Rs=0 Rd=0.0 Rb=0 Rds=50e9 Cgso=140n Cgdo=10n Cgbo=10n Cbd=100p
+ Cj=2e-4 Cjsw=1n Is=10f N=1 Pb=.8)
.param RG=100k
.step param RG list 100k 1Meg
.ac dec 10 100 10k
.meas ac Av1k FIND V(out) AT 1k
.meas ac Vg FIND V(g) AT 1k
.meas ac Vd FIND V(d) AT 1k
.meas ac Vs FIND V(s) AT 1k
.backanno
.end

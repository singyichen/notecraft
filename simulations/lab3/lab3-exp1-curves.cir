* Lab 3 實驗一：輸出特性曲線 I_D-V_DS（講義第 6 頁原圖，R1 1 kΩ 串在源極）
* 注意：R1 在源極，電源讀數 V_GS/V_DS 不等於元件端點電壓（源極退化）
VGS g 0 2
VDS d 0 5
M1 d g s s BS170
R1 s 0 1k
* --- 2N7000 的替身：LTspice 內建 standard.mos 的 BS170（同族 60 V／500 mA／TO-92 小訊號 NMOS）---
.model BS170 NMOS (Level=3 W=200u L=1u Tox=0.05u Vto=2.14 Kp=4e-4 Vmax=0 Uo=700
+ Phi=0.6 NSUB=1e15 NFS=9e11 Gamma=0.1 Delta=0 Eta=0 Theta=0 Kappa=0.005
+ Rg=0 Rs=0 Rd=0.0 Rb=0 Rds=50e9 Cgso=140n Cgdo=10n Cgbo=10n Cbd=100p
+ Cj=2e-4 Cjsw=1n Is=10f N=1 Pb=.8)
.dc VDS 0 5 0.01 VGS 0 6 2
.backanno
.end

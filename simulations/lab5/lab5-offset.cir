* ---- uA741 Boyle macromodel (TI/PSpice, supply = +/-15 V) -------------------
* connections:   1 = non-inverting in, 2 = inverting in,
*                3 = V+, 4 = V-, 5 = output
.subckt uA741 1 2 3 4 5
  c1   11 12 8.661E-12
  c2    6  7 30.00E-12
  dc    5 53 dx
  de   54  5 dx
  dlp  90 91 dx
  dln  92 90 dx
  dp    4  3 dx
  egnd 99  0 poly(2) (3,0) (4,0) 0 .5 .5
  fb    7 99 poly(5) vb vc ve vlp vln 0 10.61E6 -10E6 10E6 10E6 -10E6
  ga    6  0 11 12 188.5E-6
  gcm   0  6 10 99 5.961E-9
  iee  10  4 dc 15.16E-6
  hlim 90  0 vlim 1K
  q1   11  2 13 qx
  q2   12  1 14 qx
  r2    6  9 100.0E3
  rc1   3 11 5.305E3
  rc2   3 12 5.305E3
  re1  13 10 1.836E3
  re2  14 10 1.836E3
  ree  10 99 13.19E6
  ro1   8  5 50
  ro2   7 99 100
  rp    3  4 18.16E3
  vb    9  0 dc 0
  vc    3 53 dc 1
  ve   54  4 dc 1
  vlim  7  8 dc 0
  vlp  91  0 dc 40
  vln   0 92 dc 40
.model dx D(Is=800.0E-18 Rs=1)
.model qx NPN(Is=800.0E-18 Bf=93.75)
.ends uA741
* ---------------------------------------------------------------------------
* Lab 5：三個電路在輸入全部接地時的輸出直流偏移（偏壓電流 × 等效電阻）
VP   vcc 0 DC 15
VN   vee 0 DC -15
* 反相加法器
XU1  0 inm1 vcc vee vo1 uA741
R11  0 inm1 10k
R21  0 inm1 10k
R31  vo1 inm1 10k
* 同相加法器
XU2  inp2 inm2 vcc vee vo2 uA741
R12  0 inp2 10k
R22  0 inp2 10k
R42  0 inm2 10k
R32  vo2 inm2 10k
* 減法器
XU3  inp3 inm3 vcc vee vo3 uA741
R13  0 inp3 10k
R23  inp3 0 10k
R33  0 inm3 10k
R43  vo3 inm3 10k
.op
.end

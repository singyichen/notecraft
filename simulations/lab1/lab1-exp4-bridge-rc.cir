* Lab 1 實驗四：全波橋式整流加濾波電容（C = 1 µF / 10 µF / 100 µF）
Vin a b SINE(0 2.5 60)
Da a p 1N4007
Db b p 1N4007
Dc 0 a 1N4007
Dd 0 b 1N4007
RL p 0 10k
C1 p 0 {C}
.step param C list 1u 10u 100u
.model 1N4007 D(Is=90p Rs=40m Cjo=30p N=1.4 TT=5u Bv=1000 Ibv=5u Iave=1 Vpk=1000 mfg=Diodes_Inc. type=silicon)
.tran 0 3 0 50u
.end

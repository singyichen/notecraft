* Lab 1 實驗一：順偏 I-V 掃描（Vs 0→2 V、R 1 kΩ、1N4007）
Vs in 0 DC 0
R1 in a 1k
D1 a 0 1N4007
.model 1N4007 D(Is=90p Rs=40m Cjo=30p N=1.4 TT=5u Bv=1000 Ibv=5u Iave=1 Vpk=1000 mfg=Diodes_Inc. type=silicon)
.dc Vs 0 2 0.01
.end

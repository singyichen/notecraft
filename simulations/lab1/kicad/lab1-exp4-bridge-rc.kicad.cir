.title KiCad schematic
.model __D3 D
+           is=90p
+           rs=40m
+           n=1.4
+           tt=5u
+           cjo=30p
+           bv=1000
+           ibv=5u
.model __D2 D
+           is=90p
+           rs=40m
+           n=1.4
+           tt=5u
+           cjo=30p
+           bv=1000
+           ibv=5u
.model __D1 D
+           is=90p
+           rs=40m
+           n=1.4
+           tt=5u
+           cjo=30p
+           bv=1000
+           ibv=5u
.model __D4 D
+           is=90p
+           rs=40m
+           n=1.4
+           tt=5u
+           cjo=30p
+           bv=1000
+           ibv=5u
D3 Net-_D2-K_ Net-_D3-K_ __D3
D2 GND Net-_D2-K_ __D2
D1 GND Net-_D1-K_ __D1
V1 Net-_D2-K_ Net-_D1-K_ DC SINE(0 2.5 60)
D4 Net-_D1-K_ Net-_D3-K_ __D4
C1 Net-_D3-K_ GND 1u
RL Net-_D3-K_ GND 10k
.end

* Lab 1 實驗四：全波橋式整流（60 Hz、5 Vpp、4×1N4007、RL 10 kΩ）
Vin a b SINE(0 2.5 60)
Da a p 1N4007
Db b p 1N4007
Dc 0 a 1N4007
Dd 0 b 1N4007
RL p 0 10k
.model 1N4007 D(Is=90p Rs=40m Cjo=30p N=1.4 TT=5u Bv=1000 Ibv=5u Iave=1 Vpk=1000 mfg=Diodes_Inc. type=silicon)
.tran 0 50m 0 10u
.end

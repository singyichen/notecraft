* Lab 2 實驗二 講義問題 2、3：原電路（VBB = VCC = 15 V、R1 10k、R2 4.7k）換 RC、換 β 後的工作點
* .step RC：1k（原值）／500（用 Table 2 的 β_forced 反推）／100／60／30；.step BF：50／100／200（講義問題 3）
.param RC=1k BF=200
VBB bb 0 DC 15
VCC cc 0 DC 15
R1 bb b 10k
R2 b 0 4.7k
RC cc c {RC}
Q1 c b 0 2N2222
.model 2N2222 NPN(IS=1E-14 VAF=100
+   BF={BF} IKF=0.3 XTB=1.5 BR=3
+   CJC=8E-12 CJE=25E-12 TR=100E-9 TF=400E-12
+   ITF=1 VTF=2 XTF=3 RB=10 RC=.3 RE=.2 Vceo=30 Icrating=800m  mfg=NXP)
.step param RC list 1k 500 100 60 30
.step param BF list 50 100 200
.op
.end

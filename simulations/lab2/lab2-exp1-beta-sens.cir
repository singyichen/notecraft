* Lab 2 講義問題 3 的對照：主動區工作點（VBB 2.4 V、VCC 15 V）對 β 的敏感度，無射極電阻
.param BF=200
VBB bb 0 DC 2.4
VCC cc 0 DC 15
R1 bb b 10k
R2 b 0 4.7k
RC cc c 1k
Q1 c b 0 2N2222
.model 2N2222 NPN(IS=1E-14 VAF=100
+   BF={BF} IKF=0.3 XTB=1.5 BR=3
+   CJC=8E-12 CJE=25E-12 TR=100E-9 TF=400E-12
+   ITF=1 VTF=2 XTF=3 RB=10 RC=.3 RE=.2 Vceo=30 Icrating=800m  mfg=NXP)
.step param BF list 50 100 200
.op
.end

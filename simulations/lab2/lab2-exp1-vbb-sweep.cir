* Lab 2 實驗一補充：固定 VCC 15 V，掃 VBB 0→3 V 看 ON/OFF 門檻（IB、IC、VBE 對 VBB）
VBB bb 0 DC 0
VCC cc 0 DC 15
R1 bb b 10k
R2 b 0 4.7k
RC cc c 1k
Q1 c b 0 2N2222
.model 2N2222 NPN(IS=1E-14 VAF=100
+   BF=200 IKF=0.3 XTB=1.5 BR=3
+   CJC=8E-12 CJE=25E-12 TR=100E-9 TF=400E-12
+   ITF=1 VTF=2 XTF=3 RB=10 RC=.3 RE=.2 Vceo=30 Icrating=800m  mfg=NXP)
.dc VBB 0 3 0.005
.end

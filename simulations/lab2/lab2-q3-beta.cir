* Lab 2 講義問題 3：β 從 100 降到 50，原電路（飽和）的 Q 點會不會明顯改變
.param BFX=100
VBB bb 0 DC 15
VCC cc 0 DC 15
R1 bb b 10k
R2 b 0 4.7k
RC cc c 1k
Q1 c b 0 2N2222
.model 2N2222 NPN(IS=1E-14 VAF=100
+   BF={BFX} IKF=0.3 XTB=1.5 BR=3
+   CJC=8E-12 CJE=25E-12 TR=100E-9 TF=400E-12
+   ITF=1 VTF=2 XTF=3 RB=10 RC=.3 RE=.2 Vceo=30 Icrating=800m  mfg=NXP)
.step param BFX list 50 100 200
.op
.end

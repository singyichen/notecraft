* Lab 2 Bonus 穩健版：射極電阻拆成未旁路 RE1a 與被 C3 旁路的 RE1b，增益改由電阻比決定
* 掃 RC1 找 |Av| = 20（對 Vs），RE1a = 22 Ω、RE1b = 1 kΩ、C3 = 100 µF
.param RCX=560
V1 vcc 0 DC 12
Vs s 0 AC 1
RS1 s sin 100
C1 sin b 1u
R1 vcc b 10k
R2 b 0 10k
RC1 vcc c {RCX}
Q1 c b e 2N2222
RE1a e ea 22
RE1b ea 0 1k
C3 ea 0 100u
C2 c out 1u
RL1 out 0 10k
.model 2N2222 NPN(IS=1E-14 VAF=100
+   BF=200 IKF=0.3 XTB=1.5 BR=3
+   CJC=8E-12 CJE=25E-12 TR=100E-9 TF=400E-12
+   ITF=1 VTF=2 XTF=3 RB=10 RC=.3 RE=.2 Vceo=30 Icrating=800m  mfg=NXP)
.step param RCX list 470 510 560 620 680 750
.ac dec 50 100 1Meg
.meas AC avs FIND mag(V(out)) AT 10k
.end

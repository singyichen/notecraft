* Lab 2 第二部分 Bonus 定案設計：RC1 120 Ω、C3 100 µF，其餘不動 → |Av| ≈ 20（對函數產生器輸出 Vs）
* 時域驗證：10 kHz、Vs 50 mV 峰值（100 mVpp），看是否仍未失真，並取工作點
V1 vcc 0 DC 12
Vs s 0 SIN(0 0.05 10k)
RS1 s sin 100
C1 sin b 1u
R1 vcc b 10k
R2 b 0 10k
RC1 vcc c 120
Q1 c b e 2N2222
RE1 e 0 1k
C3 e 0 100u
C2 c out 1u
RL1 out 0 10k
.model 2N2222 NPN(IS=1E-14 VAF=100
+   BF=200 IKF=0.3 XTB=1.5 BR=3
+   CJC=8E-12 CJE=25E-12 TR=100E-9 TF=400E-12
+   ITF=1 VTF=2 XTF=3 RB=10 RC=.3 RE=.2 Vceo=30 Icrating=800m  mfg=NXP)
.tran 0 60m 59.5m 0.2u
.end

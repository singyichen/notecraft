* Lab 2 第二部分 Bonus：CE 放大器要達到 Av = 20，旁路電容 C3 要多大（小訊號 AC 掃頻，看 10 kHz 的增益）
* 電阻沿用元件表的唯一組合：R1 = R2 = RL1 = 10 kΩ、RE1 = 1 kΩ、RC1 = RS1 = 100 Ω、VCC 12 V
.param C3V=1u
V1 vcc 0 DC 12
Vs s 0 AC 1
RS1 s sin 100
C1 sin b 1u
R1 vcc b 10k
R2 b 0 10k
RC1 vcc c 100
Q1 c b e 2N2222
RE1 e 0 1k
C3 e 0 {C3V}
C2 c out 1u
RL1 out 0 10k
.model 2N2222 NPN(IS=1E-14 VAF=100
+   BF=200 IKF=0.3 XTB=1.5 BR=3
+   CJC=8E-12 CJE=25E-12 TR=100E-9 TF=400E-12
+   ITF=1 VTF=2 XTF=3 RB=10 RC=.3 RE=.2 Vceo=30 Icrating=800m  mfg=NXP)
.step param C3V list 1u 4.7u 10u 22u 47u 100u 220u 470u 1000u
.ac dec 50 100 1Meg
.meas AC av10k FIND mag(V(out)) AT 10k
.meas AC av1k FIND mag(V(out)) AT 1k
.end

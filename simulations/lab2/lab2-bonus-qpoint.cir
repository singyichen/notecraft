* Lab 2 第一部分 Bonus（講義第 15 頁的電路）：單電源 15 V、R1 10k、R2 4.7k、Rc 3.9k，設計 Re 讓 Q 點落在負載線中點
* 掃 Re 找 VCE 最接近 VCC/2 = 7.5 V 的標準值
.param REX=4.7k
VCC cc 0 DC 15
R1 cc b 10k
R2 b 0 4.7k
RC cc c 3.9k
RE e 0 {REX}
Q1 c b e 2N2222
.model 2N2222 NPN(IS=1E-14 VAF=100
+   BF=200 IKF=0.3 XTB=1.5 BR=3
+   CJC=8E-12 CJE=25E-12 TR=100E-9 TF=400E-12
+   ITF=1 VTF=2 XTF=3 RB=10 RC=.3 RE=.2 Vceo=30 Icrating=800m  mfg=NXP)
.step param REX list 2.2k 3.3k 3.9k 4.3k 4.7k 5.1k 5.6k 6.8k
.op
.end
